* LTspice Simulation Netlist - LowPassFilter_1kHz
* Circuit Type: Passive RC Low-Pass Filter
* Target Cutoff Frequency: 1000.0 Hz

* Sources
V1 in 0 AC 1 SIN(0 1 1000.0)

* Components
R1 in out 1591.55
C1 out 0 0.1u

* Simulation Directives
.ac dec 20 1 100k
.tran 0 0.005 0 1u
.plot ac V(out)
.end
